ADE simulation setup
Run mode: Single Run, Sweeps and Corners
Tests:
  mos_pmos_1: cmos_char/pmos/schematic, simulator spectre
    Variables: vgs = Linear:0:1:5; vds = 5
