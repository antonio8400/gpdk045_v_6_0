ADE simulation setup
Test mos_pmos_1: cmos_char/pmos/schematic, simulator spectre
  Models: /home/ayadav/PDK/gpdk045_v_6_0/models/spectre/gpdk045.scs[tt]
  Variables: vds = 5; vgs = Linear:0:1:5
  Temperature: 27
  Analysis dc: sweep vds start=0 stop=5 (saves the operating point)
  Signals: /PM0/S (terminal)
Run mode: Single Run, Sweeps and Corners
