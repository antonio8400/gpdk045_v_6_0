ADE simulation setup
Test mos_nmos_1: mos_characteristics/nmos/schematic, simulator spectre
  Models: /home/ayadav/PDK/gpdk045_v_6_0/models/spectre/gpdk045.scs[tt]
  Variables: vds = 5; vgs = 0
  Temperature: 27
  Analysis tran: stop=0.5 errpreset=moderate
  Signals: /NM0/D (terminal)
Run mode: Single Run, Sweeps and Corners
Corners:
  model folders: /home/ayadav/PDK/gpdk045_v_6_0/models/spectre
  tt (off): gpdk045.scs[tt]
  ff (off): gpdk045.scs[ff]
  ss (off): gpdk045.scs[ss]
Setup values for test mos_nmos_1: vgs = Linear:0:1:5
