ADE simulation setup
Run mode: Single Run, Sweeps and Corners
Tests:
  mos_nmos_1: cmos_char/nmos/schematic, simulator spectre
    Variables: vgs = Linear:0:1:5; vds = 5
Corners:
  model folders: /home/ayadav/PDK/gpdk045_v_6_0/models/spectre
  tt (off): gpdk045.scs[tt]
  ff (off): gpdk045.scs[ff]
  ss (off): gpdk045.scs[ss]
