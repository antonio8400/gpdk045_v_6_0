ADE simulation setup
Run mode: Single Run, Sweeps and Corners
Tests:
  Oscillator_analysis: reliability/inv/schematic, simulator spectre
    Outputs: average(Frequency); riseTime(VT("/out") 0 nil 0 nil 10 90 nil "cycle"); RiseTime; FallTime; freq(VT("/out") "falling")
Global variables:
  vdc = 2.5
  cload = 10f
Device parameters (all switched off):
  bertlink/inv/schematic/M0.w = {From/To}Linear:2u:1u:8u{From/To}
  bertlink/inv/schematic/M0.l = M1/l@bertlink/inv/schematic
  bertlink/inv/schematic/M1.w = 2 * M0/w@bertlink/inv/schematic
  bertlink/inv/schematic/M1.l = 250n
  bertlink/osc13/schematic/C6.c = 80f:5f:120f
  bertlink/osc13/schematic/C8.c = 0.7f:0.1f:1.2f
  bertlink/osc13/schematic/C1.c = 80f:5f:120f
  bertlink/osc13/schematic/C2.c = 80f:5f:120f
  bertlink/osc13/schematic/C3.c = 80f:5f:120f
  bertlink/osc13/schematic/C4.c = 80f:5f:120f
  bertlink/osc13/schematic/C5.c = 80f:5f:120f
Specs:
  Oscillator_analysis / RiseTime: < 1.5n
  Oscillator_analysis / FallTime: < 6n
